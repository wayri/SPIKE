* Original SPIKE finite-shunt fault fixture, SPDX-License-Identifier: Apache-2.0
VDD vdd 0 5
RLOAD vdd drain 100
VCMD command 0 5
RGATE command gate 1k
M1 drain gate 0 0 SWITCH W=10u L=1u
.model SWITCH NMOS(LEVEL=1 VTO=1 KP=100u)
D1 0 drain BODY
.model BODY D(IS=1e-12 N=1)
.tran 1u 100u uic
.end
