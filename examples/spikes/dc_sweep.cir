.title SPIKES voltage-divider DC sweep
V1 in 0 0V
R1 in out 1kOhm
R2 out 0 1kOhm
.dc V1 0V 12V 1V
.end
