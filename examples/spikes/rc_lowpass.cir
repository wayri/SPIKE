.title SPIKES explicit AC low-pass example
V1 in 0 0
R1 in out 1k
C1 out 0 1u
.op
.end
