.title VESC4.12 actual phase voltage dividers - supplied input scenario
* Board-derived topology: Benjamin Vedder bldc-hardware, CC-BY-SA-4.0.
* https://github.com/vedderb/bldc-hardware/tree/f1c65014d0caab5d99d888fc3025377861ac6ae2
* https://creativecommons.org/licenses/by-sa/4.0/ ; adapted to three reduced dividers and supplied stimuli.
* Actual R23/R24, R26/R27, R32/R33 topology from pinned BLDC_4.net.
* Supplied 100 Hz phase sources, 24 V offset and 24 V amplitude; not actual motor back-EMF.
* No ADC loading/clamps, commutation, motor or controller. Experimental linear divider.
VPHASE1 H3_VS 0 PWL(0 24 0.0001 25.5069724687 0.0002 27.0079976055 0.0003 28.4971515501 0.0004 29.968557292 0.0005 31.416407865 0.0006 32.8349892644 0.0007 34.2187029976 0.0008 35.5620881784 0.0009 36.8598430795 0.001 38.106846055 0.0011 39.298175754 0.0012 40.4291305423 0.0013 41.4952470581 0.0014 42.4923178266 0.0015 43.416407865 0.0016 44.263870212 0.0017 45.0313603211 0.0018 45.7158492592 0.0019 46.3146356613 0.002 46.8253563911 0.0021 47.2459958671 0.0022 47.5748940175 0.0023 47.8107528315 0.0024 47.9526414823 0.0025 48 0.0026 47.9526414823 0.0027 47.8107528315 0.0028 47.5748940175 0.0029 47.2459958671 0.003 46.8253563911 0.0031 46.3146356613 0.0032 45.7158492592 0.0033 45.0313603211 0.0034 44.263870212 0.0035 43.416407865 0.0036 42.4923178266 0.0037 41.4952470581 0.0038 40.4291305423 0.0039 39.298175754 0.004 38.106846055 0.0041 36.8598430795 0.0042 35.5620881784 0.0043 34.2187029976 0.0044 32.8349892644 0.0045 31.416407865 0.0046 29.968557292 0.0047 28.4971515501 0.0048 27.0079976055 0.0049 25.5069724687 0.005 24 0.0051 22.4930275313 0.0052 20.9920023945 0.0053 19.5028484499 0.0054 18.031442708 0.0055 16.583592135 0.0056 15.1650107356 0.0057 13.7812970024 0.0058 12.4379118216 0.0059 11.1401569205 0.006 9.89315394498 0.0061 8.70182424603 0.0062 7.57086945771 0.0063 6.50475294189 0.0064 5.50768217338 0.0065 4.583592135 0.0066 3.73612978795 0.0067 2.96863967895 0.0068 2.28415074082 0.0069 1.68536433868 0.007 1.17464360892 0.0071 0.754004132913 0.0072 0.425105982511 0.0073 0.189247168453 0.0074 0.0473585177215 0.0075 0 0.0076 0.0473585177215 0.0077 0.189247168453 0.0078 0.425105982511 0.0079 0.754004132913 0.008 1.17464360892 0.0081 1.68536433868 0.0082 2.28415074082 0.0083 2.96863967895 0.0084 3.73612978795 0.0085 4.583592135 0.0086 5.50768217338 0.0087 6.50475294189 0.0088 7.57086945771 0.0089 8.70182424603 0.009 9.89315394498 0.0091 11.1401569205 0.0092 12.4379118216 0.0093 13.7812970024 0.0094 15.1650107356 0.0095 16.583592135 0.0096 18.031442708 0.0097 19.5028484499 0.0098 20.9920023945 0.0099 22.4930275313 0.01 24 0.0101 25.5069724687 0.0102 27.0079976055 0.0103 28.4971515501 0.0104 29.968557292 0.0105 31.416407865 0.0106 32.8349892644 0.0107 34.2187029976 0.0108 35.5620881784 0.0109 36.8598430795 0.011 38.106846055 0.0111 39.298175754 0.0112 40.4291305423 0.0113 41.4952470581 0.0114 42.4923178266 0.0115 43.416407865 0.0116 44.263870212 0.0117 45.0313603211 0.0118 45.7158492592 0.0119 46.3146356613 0.012 46.8253563911 0.0121 47.2459958671 0.0122 47.5748940175 0.0123 47.8107528315 0.0124 47.9526414823 0.0125 48 0.0126 47.9526414823 0.0127 47.8107528315 0.0128 47.5748940175 0.0129 47.2459958671 0.013 46.8253563911 0.0131 46.3146356613 0.0132 45.7158492592 0.0133 45.0313603211 0.0134 44.263870212 0.0135 43.416407865 0.0136 42.4923178266 0.0137 41.4952470581 0.0138 40.4291305423 0.0139 39.298175754 0.014 38.106846055 0.0141 36.8598430795 0.0142 35.5620881784 0.0143 34.2187029976 0.0144 32.8349892644 0.0145 31.416407865 0.0146 29.968557292 0.0147 28.4971515501 0.0148 27.0079976055 0.0149 25.5069724687 0.015 24 0.0151 22.4930275313 0.0152 20.9920023945 0.0153 19.5028484499 0.0154 18.031442708 0.0155 16.583592135 0.0156 15.1650107356 0.0157 13.7812970024 0.0158 12.4379118216 0.0159 11.1401569205 0.016 9.89315394498 0.0161 8.70182424603 0.0162 7.57086945771 0.0163 6.50475294189 0.0164 5.50768217338 0.0165 4.583592135 0.0166 3.73612978795 0.0167 2.96863967895 0.0168 2.28415074082 0.0169 1.68536433868 0.017 1.17464360892 0.0171 0.754004132913 0.0172 0.425105982511 0.0173 0.189247168453 0.0174 0.0473585177215 0.0175 0 0.0176 0.0473585177215 0.0177 0.189247168453 0.0178 0.425105982511 0.0179 0.754004132913 0.018 1.17464360892 0.0181 1.68536433868 0.0182 2.28415074082 0.0183 2.96863967895 0.0184 3.73612978795 0.0185 4.583592135 0.0186 5.50768217338 0.0187 6.50475294189 0.0188 7.57086945771 0.0189 8.70182424603 0.019 9.89315394498 0.0191 11.1401569205 0.0192 12.4379118216 0.0193 13.7812970024 0.0194 15.1650107356 0.0195 16.583592135 0.0196 18.031442708 0.0197 19.5028484499 0.0198 20.9920023945 0.0199 22.4930275313 0.02 24)
R23 H3_VS SENS1 39k
R24 SENS1 0 2.2k
VPHASE2 H2_VS 0 PWL(0 44.7846096908 0.0001 43.990109777 0.0002 43.1167180326 0.0003 42.1678813356 0.0004 41.1473443112 0.0005 40.0591345526 0.0006 38.9075467267 0.0007 37.6971256244 0.0008 36.432648225 0.0009 35.1191048429 0.001 33.7616794338 0.0011 32.3657291357 0.0012 30.9367631267 0.0013 29.4804208827 0.0014 28.0024499212 0.0015 26.5086831184 0.0016 25.0050156895 0.0017 23.4973819228 0.0018 21.99173176 0.0019 20.4940073145 0.002 19.0101194204 0.0021 17.5459243052 0.0022 16.1072004783 0.0023 14.6996259251 0.0024 13.3287556996 0.0025 12 0.0026 10.7186028182 0.0027 9.4896212433 0.0028 8.31790550424 0.0029 7.20807982768 0.003 6.16452418854 0.0031 5.19135702418 0.0032 4.29241898079 0.0033 3.47125775615 0.0034 2.73111409845 0.0035 2.07490901658 0.0036 1.50523225219 0.0037 1.02433205923 0.0038 0.634106331044 0.0039 0.336095110308 0.004 0.131474511161 0.0041 0.0210520776274 0.0042 0.00526359660371 0.0043 0.0841713780119 0.0044 0.257464008888 0.0045 0.524457582389 0.0046 0.884098396856 0.0047 1.3349671143 0.0048 1.87528436188 0.0049 2.50291775425 0.005 3.21539030917 0.0051 4.00989022296 0.0052 4.88328196742 0.0053 5.83211866436 0.0054 6.85265568881 0.0055 7.94086544739 0.0056 9.09245327332 0.0057 10.3028743756 0.0058 11.567351775 0.0059 12.8808951571 0.006 14.2383205662 0.0061 15.6342708643 0.0062 17.0632368733 0.0063 18.5195791173 0.0064 19.9975500788 0.0065 21.4913168816 0.0066 22.9949843105 0.0067 24.5026180772 0.0068 26.00826824 0.0069 27.5059926855 0.007 28.9898805796 0.0071 30.4540756948 0.0072 31.8927995217 0.0073 33.3003740749 0.0074 34.6712443004 0.0075 36 0.0076 37.2813971818 0.0077 38.5103787567 0.0078 39.6820944958 0.0079 40.7919201723 0.008 41.8354758115 0.0081 42.8086429758 0.0082 43.7075810192 0.0083 44.5287422439 0.0084 45.2688859015 0.0085 45.9250909834 0.0086 46.4947677478 0.0087 46.9756679408 0.0088 47.365893669 0.0089 47.6639048897 0.009 47.8685254888 0.0091 47.9789479224 0.0092 47.9947364034 0.0093 47.915828622 0.0094 47.7425359911 0.0095 47.4755424176 0.0096 47.1159016031 0.0097 46.6650328857 0.0098 46.1247156381 0.0099 45.4970822457 0.01 44.7846096908 0.0101 43.990109777 0.0102 43.1167180326 0.0103 42.1678813356 0.0104 41.1473443112 0.0105 40.0591345526 0.0106 38.9075467267 0.0107 37.6971256244 0.0108 36.432648225 0.0109 35.1191048429 0.011 33.7616794338 0.0111 32.3657291357 0.0112 30.9367631267 0.0113 29.4804208827 0.0114 28.0024499212 0.0115 26.5086831184 0.0116 25.0050156895 0.0117 23.4973819228 0.0118 21.99173176 0.0119 20.4940073145 0.012 19.0101194204 0.0121 17.5459243052 0.0122 16.1072004783 0.0123 14.6996259251 0.0124 13.3287556996 0.0125 12 0.0126 10.7186028182 0.0127 9.4896212433 0.0128 8.31790550424 0.0129 7.20807982768 0.013 6.16452418854 0.0131 5.19135702418 0.0132 4.29241898079 0.0133 3.47125775615 0.0134 2.73111409845 0.0135 2.07490901658 0.0136 1.50523225219 0.0137 1.02433205923 0.0138 0.634106331044 0.0139 0.336095110308 0.014 0.131474511161 0.0141 0.0210520776274 0.0142 0.00526359660371 0.0143 0.0841713780119 0.0144 0.257464008888 0.0145 0.524457582389 0.0146 0.884098396856 0.0147 1.3349671143 0.0148 1.87528436188 0.0149 2.50291775425 0.015 3.21539030917 0.0151 4.00989022296 0.0152 4.88328196742 0.0153 5.83211866436 0.0154 6.85265568881 0.0155 7.94086544739 0.0156 9.09245327332 0.0157 10.3028743756 0.0158 11.567351775 0.0159 12.8808951571 0.016 14.2383205662 0.0161 15.6342708643 0.0162 17.0632368733 0.0163 18.5195791173 0.0164 19.9975500788 0.0165 21.4913168816 0.0166 22.9949843105 0.0167 24.5026180772 0.0168 26.00826824 0.0169 27.5059926855 0.017 28.9898805796 0.0171 30.4540756948 0.0172 31.8927995217 0.0173 33.3003740749 0.0174 34.6712443004 0.0175 36 0.0176 37.2813971818 0.0177 38.5103787567 0.0178 39.6820944958 0.0179 40.7919201723 0.018 41.8354758115 0.0181 42.8086429758 0.0182 43.7075810192 0.0183 44.5287422439 0.0184 45.2688859015 0.0185 45.9250909834 0.0186 46.4947677478 0.0187 46.9756679408 0.0188 47.365893669 0.0189 47.6639048897 0.019 47.8685254888 0.0191 47.9789479224 0.0192 47.9947364034 0.0193 47.915828622 0.0194 47.7425359911 0.0195 47.4755424176 0.0196 47.1159016031 0.0197 46.6650328857 0.0198 46.1247156381 0.0199 45.4970822457 0.02 44.7846096908)
R26 H2_VS SENS2 39k
R27 SENS2 0 2.2k
VPHASE3 H1_VS 0 PWL(0 3.21539030917 0.0001 2.50291775425 0.0002 1.87528436188 0.0003 1.3349671143 0.0004 0.884098396856 0.0005 0.524457582389 0.0006 0.257464008888 0.0007 0.0841713780119 0.0008 0.00526359660371 0.0009 0.0210520776274 0.001 0.131474511161 0.0011 0.336095110308 0.0012 0.634106331044 0.0013 1.02433205923 0.0014 1.50523225219 0.0015 2.07490901658 0.0016 2.73111409845 0.0017 3.47125775615 0.0018 4.29241898079 0.0019 5.19135702418 0.002 6.16452418854 0.0021 7.20807982768 0.0022 8.31790550424 0.0023 9.4896212433 0.0024 10.7186028182 0.0025 12 0.0026 13.3287556996 0.0027 14.6996259251 0.0028 16.1072004783 0.0029 17.5459243052 0.003 19.0101194204 0.0031 20.4940073145 0.0032 21.99173176 0.0033 23.4973819228 0.0034 25.0050156895 0.0035 26.5086831184 0.0036 28.0024499212 0.0037 29.4804208827 0.0038 30.9367631267 0.0039 32.3657291357 0.004 33.7616794338 0.0041 35.1191048429 0.0042 36.432648225 0.0043 37.6971256244 0.0044 38.9075467267 0.0045 40.0591345526 0.0046 41.1473443112 0.0047 42.1678813356 0.0048 43.1167180326 0.0049 43.990109777 0.005 44.7846096908 0.0051 45.4970822457 0.0052 46.1247156381 0.0053 46.6650328857 0.0054 47.1159016031 0.0055 47.4755424176 0.0056 47.7425359911 0.0057 47.915828622 0.0058 47.9947364034 0.0059 47.9789479224 0.006 47.8685254888 0.0061 47.6639048897 0.0062 47.365893669 0.0063 46.9756679408 0.0064 46.4947677478 0.0065 45.9250909834 0.0066 45.2688859015 0.0067 44.5287422439 0.0068 43.7075810192 0.0069 42.8086429758 0.007 41.8354758115 0.0071 40.7919201723 0.0072 39.6820944958 0.0073 38.5103787567 0.0074 37.2813971818 0.0075 36 0.0076 34.6712443004 0.0077 33.3003740749 0.0078 31.8927995217 0.0079 30.4540756948 0.008 28.9898805796 0.0081 27.5059926855 0.0082 26.00826824 0.0083 24.5026180772 0.0084 22.9949843105 0.0085 21.4913168816 0.0086 19.9975500788 0.0087 18.5195791173 0.0088 17.0632368733 0.0089 15.6342708643 0.009 14.2383205662 0.0091 12.8808951571 0.0092 11.567351775 0.0093 10.3028743756 0.0094 9.09245327332 0.0095 7.94086544739 0.0096 6.85265568881 0.0097 5.83211866436 0.0098 4.88328196742 0.0099 4.00989022296 0.01 3.21539030917 0.0101 2.50291775425 0.0102 1.87528436188 0.0103 1.3349671143 0.0104 0.884098396856 0.0105 0.524457582389 0.0106 0.257464008888 0.0107 0.0841713780119 0.0108 0.00526359660371 0.0109 0.0210520776274 0.011 0.131474511161 0.0111 0.336095110308 0.0112 0.634106331044 0.0113 1.02433205923 0.0114 1.50523225219 0.0115 2.07490901658 0.0116 2.73111409845 0.0117 3.47125775615 0.0118 4.29241898079 0.0119 5.19135702418 0.012 6.16452418854 0.0121 7.20807982768 0.0122 8.31790550424 0.0123 9.4896212433 0.0124 10.7186028182 0.0125 12 0.0126 13.3287556996 0.0127 14.6996259251 0.0128 16.1072004783 0.0129 17.5459243052 0.013 19.0101194204 0.0131 20.4940073145 0.0132 21.99173176 0.0133 23.4973819228 0.0134 25.0050156895 0.0135 26.5086831184 0.0136 28.0024499212 0.0137 29.4804208827 0.0138 30.9367631267 0.0139 32.3657291357 0.014 33.7616794338 0.0141 35.1191048429 0.0142 36.432648225 0.0143 37.6971256244 0.0144 38.9075467267 0.0145 40.0591345526 0.0146 41.1473443112 0.0147 42.1678813356 0.0148 43.1167180326 0.0149 43.990109777 0.015 44.7846096908 0.0151 45.4970822457 0.0152 46.1247156381 0.0153 46.6650328857 0.0154 47.1159016031 0.0155 47.4755424176 0.0156 47.7425359911 0.0157 47.915828622 0.0158 47.9947364034 0.0159 47.9789479224 0.016 47.8685254888 0.0161 47.6639048897 0.0162 47.365893669 0.0163 46.9756679408 0.0164 46.4947677478 0.0165 45.9250909834 0.0166 45.2688859015 0.0167 44.5287422439 0.0168 43.7075810192 0.0169 42.8086429758 0.017 41.8354758115 0.0171 40.7919201723 0.0172 39.6820944958 0.0173 38.5103787567 0.0174 37.2813971818 0.0175 36 0.0176 34.6712443004 0.0177 33.3003740749 0.0178 31.8927995217 0.0179 30.4540756948 0.018 28.9898805796 0.0181 27.5059926855 0.0182 26.00826824 0.0183 24.5026180772 0.0184 22.9949843105 0.0185 21.4913168816 0.0186 19.9975500788 0.0187 18.5195791173 0.0188 17.0632368733 0.0189 15.6342708643 0.019 14.2383205662 0.0191 12.8808951571 0.0192 11.567351775 0.0193 10.3028743756 0.0194 9.09245327332 0.0195 7.94086544739 0.0196 6.85265568881 0.0197 5.83211866436 0.0198 4.88328196742 0.0199 4.00989022296 0.02 3.21539030917)
R32 H1_VS SENS3 39k
R33 SENS3 0 2.2k
.tran 10u 20m
.end
