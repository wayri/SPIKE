.title Original ESC teaching example - supplied phase back-EMF sensing
* Supplied ideal 100 Hz phase EMF, not a solved rotating three-phase motor.
* 200k/10k divider; buffered 1.65V offset; 1k/100n low-pass.
Vphase phase 0 PWL(0 0 0.0001 1.5069724687 0.0002 3.00799760554 0.0003 4.49715155006 0.0004 5.96855729196 0.0005 7.416407865 0.0006 8.83498926443 0.0007 10.2187029976 0.0008 11.5620881784 0.0009 12.8598430795 0.001 14.106846055 0.0011 15.298175754 0.0012 16.4291305423 0.0013 17.4952470581 0.0014 18.4923178266 0.0015 19.416407865 0.0016 20.263870212 0.0017 21.0313603211 0.0018 21.7158492592 0.0019 22.3146356613 0.002 22.8253563911 0.0021 23.2459958671 0.0022 23.5748940175 0.0023 23.8107528315 0.0024 23.9526414823 0.0025 24 0.0026 23.9526414823 0.0027 23.8107528315 0.0028 23.5748940175 0.0029 23.2459958671 0.003 22.8253563911 0.0031 22.3146356613 0.0032 21.7158492592 0.0033 21.0313603211 0.0034 20.263870212 0.0035 19.416407865 0.0036 18.4923178266 0.0037 17.4952470581 0.0038 16.4291305423 0.0039 15.298175754 0.004 14.106846055 0.0041 12.8598430795 0.0042 11.5620881784 0.0043 10.2187029976 0.0044 8.83498926443 0.0045 7.416407865 0.0046 5.96855729196 0.0047 4.49715155006 0.0048 3.00799760554 0.0049 1.5069724687 0.005 -7.71898871845e-15 0.0051 -1.5069724687 0.0052 -3.00799760554 0.0053 -4.49715155006 0.0054 -5.96855729196 0.0055 -7.416407865 0.0056 -8.83498926443 0.0057 -10.2187029976 0.0058 -11.5620881784 0.0059 -12.8598430795 0.006 -14.106846055 0.0061 -15.298175754 0.0062 -16.4291305423 0.0063 -17.4952470581 0.0064 -18.4923178266 0.0065 -19.416407865 0.0066 -20.263870212 0.0067 -21.0313603211 0.0068 -21.7158492592 0.0069 -22.3146356613 0.007 -22.8253563911 0.0071 -23.2459958671 0.0072 -23.5748940175 0.0073 -23.8107528315 0.0074 -23.9526414823 0.0075 -24 0.0076 -23.9526414823 0.0077 -23.8107528315 0.0078 -23.5748940175 0.0079 -23.2459958671 0.008 -22.8253563911 0.0081 -22.3146356613 0.0082 -21.7158492592 0.0083 -21.0313603211 0.0084 -20.263870212 0.0085 -19.416407865 0.0086 -18.4923178266 0.0087 -17.4952470581 0.0088 -16.4291305423 0.0089 -15.298175754 0.009 -14.106846055 0.0091 -12.8598430795 0.0092 -11.5620881784 0.0093 -10.2187029976 0.0094 -8.83498926443 0.0095 -7.416407865 0.0096 -5.96855729196 0.0097 -4.49715155006 0.0098 -3.00799760554 0.0099 -1.5069724687 0.01 1.54379774369e-14 0.0101 1.5069724687 0.0102 3.00799760554 0.0103 4.49715155006 0.0104 5.96855729196 0.0105 7.416407865 0.0106 8.83498926443 0.0107 10.2187029976 0.0108 11.5620881784 0.0109 12.8598430795 0.011 14.106846055 0.0111 15.298175754 0.0112 16.4291305423 0.0113 17.4952470581 0.0114 18.4923178266 0.0115 19.416407865 0.0116 20.263870212 0.0117 21.0313603211 0.0118 21.7158492592 0.0119 22.3146356613 0.012 22.8253563911 0.0121 23.2459958671 0.0122 23.5748940175 0.0123 23.8107528315 0.0124 23.9526414823 0.0125 24 0.0126 23.9526414823 0.0127 23.8107528315 0.0128 23.5748940175 0.0129 23.2459958671 0.013 22.8253563911 0.0131 22.3146356613 0.0132 21.7158492592 0.0133 21.0313603211 0.0134 20.263870212 0.0135 19.416407865 0.0136 18.4923178266 0.0137 17.4952470581 0.0138 16.4291305423 0.0139 15.298175754 0.014 14.106846055 0.0141 12.8598430795 0.0142 11.5620881784 0.0143 10.2187029976 0.0144 8.83498926443 0.0145 7.416407865 0.0146 5.96855729196 0.0147 4.49715155006 0.0148 3.00799760554 0.0149 1.5069724687 0.015 8.81745695386e-15 0.0151 -1.5069724687 0.0152 -3.00799760554 0.0153 -4.49715155006 0.0154 -5.96855729196 0.0155 -7.416407865 0.0156 -8.83498926443 0.0157 -10.2187029976 0.0158 -11.5620881784 0.0159 -12.8598430795 0.016 -14.106846055 0.0161 -15.298175754 0.0162 -16.4291305423 0.0163 -17.4952470581 0.0164 -18.4923178266 0.0165 -19.416407865 0.0166 -20.263870212 0.0167 -21.0313603211 0.0168 -21.7158492592 0.0169 -22.3146356613 0.017 -22.8253563911 0.0171 -23.2459958671 0.0172 -23.5748940175 0.0173 -23.8107528315 0.0174 -23.9526414823 0.0175 -24 0.0176 -23.9526414823 0.0177 -23.8107528315 0.0178 -23.5748940175 0.0179 -23.2459958671 0.018 -22.8253563911 0.0181 -22.3146356613 0.0182 -21.7158492592 0.0183 -21.0313603211 0.0184 -20.263870212 0.0185 -19.416407865 0.0186 -18.4923178266 0.0187 -17.4952470581 0.0188 -16.4291305423 0.0189 -15.298175754 0.019 -14.106846055 0.0191 -12.8598430795 0.0192 -11.5620881784 0.0193 -10.2187029976 0.0194 -8.83498926443 0.0195 -7.416407865 0.0196 -5.96855729196 0.0197 -4.49715155006 0.0198 -3.00799760554 0.0199 -1.5069724687 0.02 3.08759548738e-14 0.0201 1.5069724687 0.0202 3.00799760554 0.0203 4.49715155006 0.0204 5.96855729196 0.0205 7.416407865 0.0206 8.83498926443 0.0207 10.2187029976 0.0208 11.5620881784 0.0209 12.8598430795 0.021 14.106846055 0.0211 15.298175754 0.0212 16.4291305423 0.0213 17.4952470581 0.0214 18.4923178266 0.0215 19.416407865 0.0216 20.263870212 0.0217 21.0313603211 0.0218 21.7158492592 0.0219 22.3146356613 0.022 22.8253563911 0.0221 23.2459958671 0.0222 23.5748940175 0.0223 23.8107528315 0.0224 23.9526414823 0.0225 24 0.0226 23.9526414823 0.0227 23.8107528315 0.0228 23.5748940175 0.0229 23.2459958671 0.023 22.8253563911 0.0231 22.3146356613 0.0232 21.7158492592 0.0233 21.0313603211 0.0234 20.263870212 0.0235 19.416407865 0.0236 18.4923178266 0.0237 17.4952470581 0.0238 16.4291305423 0.0239 15.298175754 0.024 14.106846055 0.0241 12.8598430795 0.0242 11.5620881784 0.0243 10.2187029976 0.0244 8.83498926443 0.0245 7.416407865 0.0246 5.96855729196 0.0247 4.49715155006 0.0248 3.00799760554 0.0249 1.5069724687 0.025 -2.79368025558e-14 0.0251 -1.5069724687 0.0252 -3.00799760554 0.0253 -4.49715155006 0.0254 -5.96855729196 0.0255 -7.416407865 0.0256 -8.83498926443 0.0257 -10.2187029976 0.0258 -11.5620881784 0.0259 -12.8598430795 0.026 -14.106846055 0.0261 -15.298175754 0.0262 -16.4291305423 0.0263 -17.4952470581 0.0264 -18.4923178266 0.0265 -19.416407865 0.0266 -20.263870212 0.0267 -21.0313603211 0.0268 -21.7158492592 0.0269 -22.3146356613 0.027 -22.8253563911 0.0271 -23.2459958671 0.0272 -23.5748940175 0.0273 -23.8107528315 0.0274 -23.9526414823 0.0275 -24 0.0276 -23.9526414823 0.0277 -23.8107528315 0.0278 -23.5748940175 0.0279 -23.2459958671 0.028 -22.8253563911 0.0281 -22.3146356613 0.0282 -21.7158492592 0.0283 -21.0313603211 0.0284 -20.263870212 0.0285 -19.416407865 0.0286 -18.4923178266 0.0287 -17.4952470581 0.0288 -16.4291305423 0.0289 -15.298175754 0.029 -14.106846055 0.0291 -12.8598430795 0.0292 -11.5620881784 0.0293 -10.2187029976 0.0294 -8.83498926443 0.0295 -7.416407865 0.0296 -5.96855729196 0.0297 -4.49715155006 0.0298 -3.00799760554 0.0299 -1.5069724687 0.03 -1.76349139077e-14 0.0301 1.5069724687 0.0302 3.00799760554 0.0303 4.49715155006 0.0304 5.96855729196 0.0305 7.416407865 0.0306 8.83498926443 0.0307 10.2187029976 0.0308 11.5620881784 0.0309 12.8598430795 0.031 14.106846055 0.0311 15.298175754 0.0312 16.4291305423 0.0313 17.4952470581 0.0314 18.4923178266 0.0315 19.416407865 0.0316 20.263870212 0.0317 21.0313603211 0.0318 21.7158492592 0.0319 22.3146356613 0.032 22.8253563911 0.0321 23.2459958671 0.0322 23.5748940175 0.0323 23.8107528315 0.0324 23.9526414823 0.0325 24 0.0326 23.9526414823 0.0327 23.8107528315 0.0328 23.5748940175 0.0329 23.2459958671 0.033 22.8253563911 0.0331 22.3146356613 0.0332 21.7158492592 0.0333 21.0313603211 0.0334 20.263870212 0.0335 19.416407865 0.0336 18.4923178266 0.0337 17.4952470581 0.0338 16.4291305423 0.0339 15.298175754 0.034 14.106846055 0.0341 12.8598430795 0.0342 11.5620881784 0.0343 10.2187029976 0.0344 8.83498926443 0.0345 7.416407865 0.0346 5.96855729196 0.0347 4.49715155006 0.0348 3.00799760554 0.0349 1.5069724687 0.035 -6.46910620655e-14 0.0351 -1.5069724687 0.0352 -3.00799760554 0.0353 -4.49715155006 0.0354 -5.96855729196 0.0355 -7.416407865 0.0356 -8.83498926443 0.0357 -10.2187029976 0.0358 -11.5620881784 0.0359 -12.8598430795 0.036 -14.106846055 0.0361 -15.298175754 0.0362 -16.4291305423 0.0363 -17.4952470581 0.0364 -18.4923178266 0.0365 -19.416407865 0.0366 -20.263870212 0.0367 -21.0313603211 0.0368 -21.7158492592 0.0369 -22.3146356613 0.037 -22.8253563911 0.0371 -23.2459958671 0.0372 -23.5748940175 0.0373 -23.8107528315 0.0374 -23.9526414823 0.0375 -24 0.0376 -23.9526414823 0.0377 -23.8107528315 0.0378 -23.5748940175 0.0379 -23.2459958671 0.038 -22.8253563911 0.0381 -22.3146356613 0.0382 -21.7158492592 0.0383 -21.0313603211 0.0384 -20.263870212 0.0385 -19.416407865 0.0386 -18.4923178266 0.0387 -17.4952470581 0.0388 -16.4291305423 0.0389 -15.298175754 0.039 -14.106846055 0.0391 -12.8598430795 0.0392 -11.5620881784 0.0393 -10.2187029976 0.0394 -8.83498926443 0.0395 -7.416407865 0.0396 -5.96855729196 0.0397 -4.49715155006 0.0398 -3.00799760554 0.0399 -1.5069724687 0.04 6.17519097476e-14)
Rtop phase divided 200k
Rbottom divided 0 10k
Vref ref 0 1.65
Ebuffer buffered ref divided 0 1
Rfilter buffered adc 1k
Cfilter adc 0 100n
.tran 10u 40m uic
.end
