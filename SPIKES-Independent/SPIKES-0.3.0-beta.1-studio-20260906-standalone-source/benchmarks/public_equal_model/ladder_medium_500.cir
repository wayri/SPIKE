SPIKES public medium 500-section unit-resistor ladder
* SPDX-License-Identifier: CC0-1.0
* First-party deterministic sparse-MNA scale fixture
IIN 0 n499 1
R0 n0 0 1
R1 n1 n0 1
R2 n2 n1 1
R3 n3 n2 1
R4 n4 n3 1
R5 n5 n4 1
R6 n6 n5 1
R7 n7 n6 1
R8 n8 n7 1
R9 n9 n8 1
R10 n10 n9 1
R11 n11 n10 1
R12 n12 n11 1
R13 n13 n12 1
R14 n14 n13 1
R15 n15 n14 1
R16 n16 n15 1
R17 n17 n16 1
R18 n18 n17 1
R19 n19 n18 1
R20 n20 n19 1
R21 n21 n20 1
R22 n22 n21 1
R23 n23 n22 1
R24 n24 n23 1
R25 n25 n24 1
R26 n26 n25 1
R27 n27 n26 1
R28 n28 n27 1
R29 n29 n28 1
R30 n30 n29 1
R31 n31 n30 1
R32 n32 n31 1
R33 n33 n32 1
R34 n34 n33 1
R35 n35 n34 1
R36 n36 n35 1
R37 n37 n36 1
R38 n38 n37 1
R39 n39 n38 1
R40 n40 n39 1
R41 n41 n40 1
R42 n42 n41 1
R43 n43 n42 1
R44 n44 n43 1
R45 n45 n44 1
R46 n46 n45 1
R47 n47 n46 1
R48 n48 n47 1
R49 n49 n48 1
R50 n50 n49 1
R51 n51 n50 1
R52 n52 n51 1
R53 n53 n52 1
R54 n54 n53 1
R55 n55 n54 1
R56 n56 n55 1
R57 n57 n56 1
R58 n58 n57 1
R59 n59 n58 1
R60 n60 n59 1
R61 n61 n60 1
R62 n62 n61 1
R63 n63 n62 1
R64 n64 n63 1
R65 n65 n64 1
R66 n66 n65 1
R67 n67 n66 1
R68 n68 n67 1
R69 n69 n68 1
R70 n70 n69 1
R71 n71 n70 1
R72 n72 n71 1
R73 n73 n72 1
R74 n74 n73 1
R75 n75 n74 1
R76 n76 n75 1
R77 n77 n76 1
R78 n78 n77 1
R79 n79 n78 1
R80 n80 n79 1
R81 n81 n80 1
R82 n82 n81 1
R83 n83 n82 1
R84 n84 n83 1
R85 n85 n84 1
R86 n86 n85 1
R87 n87 n86 1
R88 n88 n87 1
R89 n89 n88 1
R90 n90 n89 1
R91 n91 n90 1
R92 n92 n91 1
R93 n93 n92 1
R94 n94 n93 1
R95 n95 n94 1
R96 n96 n95 1
R97 n97 n96 1
R98 n98 n97 1
R99 n99 n98 1
R100 n100 n99 1
R101 n101 n100 1
R102 n102 n101 1
R103 n103 n102 1
R104 n104 n103 1
R105 n105 n104 1
R106 n106 n105 1
R107 n107 n106 1
R108 n108 n107 1
R109 n109 n108 1
R110 n110 n109 1
R111 n111 n110 1
R112 n112 n111 1
R113 n113 n112 1
R114 n114 n113 1
R115 n115 n114 1
R116 n116 n115 1
R117 n117 n116 1
R118 n118 n117 1
R119 n119 n118 1
R120 n120 n119 1
R121 n121 n120 1
R122 n122 n121 1
R123 n123 n122 1
R124 n124 n123 1
R125 n125 n124 1
R126 n126 n125 1
R127 n127 n126 1
R128 n128 n127 1
R129 n129 n128 1
R130 n130 n129 1
R131 n131 n130 1
R132 n132 n131 1
R133 n133 n132 1
R134 n134 n133 1
R135 n135 n134 1
R136 n136 n135 1
R137 n137 n136 1
R138 n138 n137 1
R139 n139 n138 1
R140 n140 n139 1
R141 n141 n140 1
R142 n142 n141 1
R143 n143 n142 1
R144 n144 n143 1
R145 n145 n144 1
R146 n146 n145 1
R147 n147 n146 1
R148 n148 n147 1
R149 n149 n148 1
R150 n150 n149 1
R151 n151 n150 1
R152 n152 n151 1
R153 n153 n152 1
R154 n154 n153 1
R155 n155 n154 1
R156 n156 n155 1
R157 n157 n156 1
R158 n158 n157 1
R159 n159 n158 1
R160 n160 n159 1
R161 n161 n160 1
R162 n162 n161 1
R163 n163 n162 1
R164 n164 n163 1
R165 n165 n164 1
R166 n166 n165 1
R167 n167 n166 1
R168 n168 n167 1
R169 n169 n168 1
R170 n170 n169 1
R171 n171 n170 1
R172 n172 n171 1
R173 n173 n172 1
R174 n174 n173 1
R175 n175 n174 1
R176 n176 n175 1
R177 n177 n176 1
R178 n178 n177 1
R179 n179 n178 1
R180 n180 n179 1
R181 n181 n180 1
R182 n182 n181 1
R183 n183 n182 1
R184 n184 n183 1
R185 n185 n184 1
R186 n186 n185 1
R187 n187 n186 1
R188 n188 n187 1
R189 n189 n188 1
R190 n190 n189 1
R191 n191 n190 1
R192 n192 n191 1
R193 n193 n192 1
R194 n194 n193 1
R195 n195 n194 1
R196 n196 n195 1
R197 n197 n196 1
R198 n198 n197 1
R199 n199 n198 1
R200 n200 n199 1
R201 n201 n200 1
R202 n202 n201 1
R203 n203 n202 1
R204 n204 n203 1
R205 n205 n204 1
R206 n206 n205 1
R207 n207 n206 1
R208 n208 n207 1
R209 n209 n208 1
R210 n210 n209 1
R211 n211 n210 1
R212 n212 n211 1
R213 n213 n212 1
R214 n214 n213 1
R215 n215 n214 1
R216 n216 n215 1
R217 n217 n216 1
R218 n218 n217 1
R219 n219 n218 1
R220 n220 n219 1
R221 n221 n220 1
R222 n222 n221 1
R223 n223 n222 1
R224 n224 n223 1
R225 n225 n224 1
R226 n226 n225 1
R227 n227 n226 1
R228 n228 n227 1
R229 n229 n228 1
R230 n230 n229 1
R231 n231 n230 1
R232 n232 n231 1
R233 n233 n232 1
R234 n234 n233 1
R235 n235 n234 1
R236 n236 n235 1
R237 n237 n236 1
R238 n238 n237 1
R239 n239 n238 1
R240 n240 n239 1
R241 n241 n240 1
R242 n242 n241 1
R243 n243 n242 1
R244 n244 n243 1
R245 n245 n244 1
R246 n246 n245 1
R247 n247 n246 1
R248 n248 n247 1
R249 n249 n248 1
R250 n250 n249 1
R251 n251 n250 1
R252 n252 n251 1
R253 n253 n252 1
R254 n254 n253 1
R255 n255 n254 1
R256 n256 n255 1
R257 n257 n256 1
R258 n258 n257 1
R259 n259 n258 1
R260 n260 n259 1
R261 n261 n260 1
R262 n262 n261 1
R263 n263 n262 1
R264 n264 n263 1
R265 n265 n264 1
R266 n266 n265 1
R267 n267 n266 1
R268 n268 n267 1
R269 n269 n268 1
R270 n270 n269 1
R271 n271 n270 1
R272 n272 n271 1
R273 n273 n272 1
R274 n274 n273 1
R275 n275 n274 1
R276 n276 n275 1
R277 n277 n276 1
R278 n278 n277 1
R279 n279 n278 1
R280 n280 n279 1
R281 n281 n280 1
R282 n282 n281 1
R283 n283 n282 1
R284 n284 n283 1
R285 n285 n284 1
R286 n286 n285 1
R287 n287 n286 1
R288 n288 n287 1
R289 n289 n288 1
R290 n290 n289 1
R291 n291 n290 1
R292 n292 n291 1
R293 n293 n292 1
R294 n294 n293 1
R295 n295 n294 1
R296 n296 n295 1
R297 n297 n296 1
R298 n298 n297 1
R299 n299 n298 1
R300 n300 n299 1
R301 n301 n300 1
R302 n302 n301 1
R303 n303 n302 1
R304 n304 n303 1
R305 n305 n304 1
R306 n306 n305 1
R307 n307 n306 1
R308 n308 n307 1
R309 n309 n308 1
R310 n310 n309 1
R311 n311 n310 1
R312 n312 n311 1
R313 n313 n312 1
R314 n314 n313 1
R315 n315 n314 1
R316 n316 n315 1
R317 n317 n316 1
R318 n318 n317 1
R319 n319 n318 1
R320 n320 n319 1
R321 n321 n320 1
R322 n322 n321 1
R323 n323 n322 1
R324 n324 n323 1
R325 n325 n324 1
R326 n326 n325 1
R327 n327 n326 1
R328 n328 n327 1
R329 n329 n328 1
R330 n330 n329 1
R331 n331 n330 1
R332 n332 n331 1
R333 n333 n332 1
R334 n334 n333 1
R335 n335 n334 1
R336 n336 n335 1
R337 n337 n336 1
R338 n338 n337 1
R339 n339 n338 1
R340 n340 n339 1
R341 n341 n340 1
R342 n342 n341 1
R343 n343 n342 1
R344 n344 n343 1
R345 n345 n344 1
R346 n346 n345 1
R347 n347 n346 1
R348 n348 n347 1
R349 n349 n348 1
R350 n350 n349 1
R351 n351 n350 1
R352 n352 n351 1
R353 n353 n352 1
R354 n354 n353 1
R355 n355 n354 1
R356 n356 n355 1
R357 n357 n356 1
R358 n358 n357 1
R359 n359 n358 1
R360 n360 n359 1
R361 n361 n360 1
R362 n362 n361 1
R363 n363 n362 1
R364 n364 n363 1
R365 n365 n364 1
R366 n366 n365 1
R367 n367 n366 1
R368 n368 n367 1
R369 n369 n368 1
R370 n370 n369 1
R371 n371 n370 1
R372 n372 n371 1
R373 n373 n372 1
R374 n374 n373 1
R375 n375 n374 1
R376 n376 n375 1
R377 n377 n376 1
R378 n378 n377 1
R379 n379 n378 1
R380 n380 n379 1
R381 n381 n380 1
R382 n382 n381 1
R383 n383 n382 1
R384 n384 n383 1
R385 n385 n384 1
R386 n386 n385 1
R387 n387 n386 1
R388 n388 n387 1
R389 n389 n388 1
R390 n390 n389 1
R391 n391 n390 1
R392 n392 n391 1
R393 n393 n392 1
R394 n394 n393 1
R395 n395 n394 1
R396 n396 n395 1
R397 n397 n396 1
R398 n398 n397 1
R399 n399 n398 1
R400 n400 n399 1
R401 n401 n400 1
R402 n402 n401 1
R403 n403 n402 1
R404 n404 n403 1
R405 n405 n404 1
R406 n406 n405 1
R407 n407 n406 1
R408 n408 n407 1
R409 n409 n408 1
R410 n410 n409 1
R411 n411 n410 1
R412 n412 n411 1
R413 n413 n412 1
R414 n414 n413 1
R415 n415 n414 1
R416 n416 n415 1
R417 n417 n416 1
R418 n418 n417 1
R419 n419 n418 1
R420 n420 n419 1
R421 n421 n420 1
R422 n422 n421 1
R423 n423 n422 1
R424 n424 n423 1
R425 n425 n424 1
R426 n426 n425 1
R427 n427 n426 1
R428 n428 n427 1
R429 n429 n428 1
R430 n430 n429 1
R431 n431 n430 1
R432 n432 n431 1
R433 n433 n432 1
R434 n434 n433 1
R435 n435 n434 1
R436 n436 n435 1
R437 n437 n436 1
R438 n438 n437 1
R439 n439 n438 1
R440 n440 n439 1
R441 n441 n440 1
R442 n442 n441 1
R443 n443 n442 1
R444 n444 n443 1
R445 n445 n444 1
R446 n446 n445 1
R447 n447 n446 1
R448 n448 n447 1
R449 n449 n448 1
R450 n450 n449 1
R451 n451 n450 1
R452 n452 n451 1
R453 n453 n452 1
R454 n454 n453 1
R455 n455 n454 1
R456 n456 n455 1
R457 n457 n456 1
R458 n458 n457 1
R459 n459 n458 1
R460 n460 n459 1
R461 n461 n460 1
R462 n462 n461 1
R463 n463 n462 1
R464 n464 n463 1
R465 n465 n464 1
R466 n466 n465 1
R467 n467 n466 1
R468 n468 n467 1
R469 n469 n468 1
R470 n470 n469 1
R471 n471 n470 1
R472 n472 n471 1
R473 n473 n472 1
R474 n474 n473 1
R475 n475 n474 1
R476 n476 n475 1
R477 n477 n476 1
R478 n478 n477 1
R479 n479 n478 1
R480 n480 n479 1
R481 n481 n480 1
R482 n482 n481 1
R483 n483 n482 1
R484 n484 n483 1
R485 n485 n484 1
R486 n486 n485 1
R487 n487 n486 1
R488 n488 n487 1
R489 n489 n488 1
R490 n490 n489 1
R491 n491 n490 1
R492 n492 n491 1
R493 n493 n492 1
R494 n494 n493 1
R495 n495 n494 1
R496 n496 n495 1
R497 n497 n496 1
R498 n498 n497 1
R499 n499 n498 1
.op
.end
